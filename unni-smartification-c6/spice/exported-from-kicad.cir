.title KiCad schematic
.include "/Users/lkolbe/work/PlatformIO/Projects/esphome-i2c-sniffer/unni-smartification-c6/spice/models/AO3400A.lib"
.include "/Users/lkolbe/work/PlatformIO/Projects/esphome-i2c-sniffer/unni-smartification-c6/spice/models/AO3401A.lib"
.include "/Users/lkolbe/work/PlatformIO/Projects/esphome-i2c-sniffer/unni-smartification-c6/spice/models/MCP73831.lib"
.include "/Users/lkolbe/work/PlatformIO/Projects/esphome-i2c-sniffer/unni-smartification-c6/spice/models/SS14.lib"
.include "/Users/lkolbe/work/PlatformIO/Projects/esphome-i2c-sniffer/unni-smartification-c6/spice/models/TPS613222A.lib"
.include "/Users/lkolbe/work/PlatformIO/Projects/esphome-i2c-sniffer/unni-smartification-c6/spice/models/TPS63031.lib"
.include "/Users/lkolbe/work/PlatformIO/Projects/esphome-i2c-sniffer/unni-smartification-c6/spice/models/USB_HOTPLUG.lib"
R11 Net-_U1-STAT_ CHARGE_STAT 150k
R1 Net-_J1-CC1_ SYS 5.1k
R6 SYS Net-_Q1-G_ 1Meg
L1 Net-_U2-L1_ Net-_U2-L2_ 1.5u
XQ2 Net-_Q2-G_ +BATT /USB_+_Power/BOOST_IN AO3401A
C6 +3V3 SYS 10u
R9 Net-_Q3-G_ SYS 1Meg
XD1 SYS SYS SS14_SUB
XU3 +5V Net-_U3-SW_ SYS TPS613222A
R12 CHARGE_STAT SYS 220k
R5 SYS Net-_Q1-G_ 100k
C8 +5V SYS 22u
R13 SYS SYS 47k
R8 BOOST_CMD Net-_Q3-G_ 10k
XU1 Net-_U1-STAT_ SYS +BATT SYS SYS MCP73831
C5 +3V3 SYS 10u
R2 Net-_J1-CC2_ SYS 5.1k
C2 +BATT SYS 4.7u
XQ1 Net-_Q1-G_ SYS +BATT AO3401A
XQ3 Net-_Q3-G_ SYS Net-_Q2-G_ AO3400A
C9 UNNI_AC SYS 1u
R3 SYS SYS 3.3k
XD4 UNNI_AC +5V SS14_SUB
R7 Net-_Q2-G_ +BATT 1Meg
C1 SYS SYS 4.7u
C4 SYS SYS 100n
XU2 +3V3 Net-_U2-L2_ SYS Net-_U2-L1_ SYS SYS SYS SYS SYS +3V3 SYS TPS63031
L2 /USB_+_Power/BOOST_IN Net-_U3-SW_ 2.2u
XQ4 SYS SYS Net-_Q3-G_ AO3400A
C7 /USB_+_Power/BOOST_IN SYS 10u
XD3 UNNI_AC SYS SS14_SUB
C3 SYS SYS 10u
R301 UNNI_AC SYS 100
V3 BOOST_CMD SYS PULSE( 0 3.3 0.5 5m 5m 4.5 6.5 )
R300 Net-_R300-Pad1_ +BATT 120m
XR310 Net-_R310-Pad1_ SYS USB_HOTPLUG
V2 Net-_R300-Pad1_ SYS DC 3.70
V1 Net-_R310-Pad1_ SYS PULSE( 0 5 3 20m 20m 3 20 )
I1 +3V3 SYS PULSE( 0.02 0.18 0.2 1m 1m 0.05 0.5 )
I2 SYS SYS PULSE( 0.02 0.18 0.2 1m 1m 0.05 0.5 )
R302 +BATT SYS 330
.end
