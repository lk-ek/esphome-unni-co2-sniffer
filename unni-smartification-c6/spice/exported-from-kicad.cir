.title KiCad schematic
.include "/mnt/data/unni_cfg/unni-smartification-c6/spice/models/AO3400A.lib"
.include "/mnt/data/unni_cfg/unni-smartification-c6/spice/models/AO3401A.lib"
.include "/mnt/data/unni_cfg/unni-smartification-c6/spice/models/MCP73831.lib"
.include "/mnt/data/unni_cfg/unni-smartification-c6/spice/models/SS14.lib"
.include "/mnt/data/unni_cfg/unni-smartification-c6/spice/models/TPS613222A.lib"
.include "/mnt/data/unni_cfg/unni-smartification-c6/spice/models/TPS63031.lib"
.include "/mnt/data/unni_cfg/unni-smartification-c6/spice/models/USB_HOTPLUG.lib"
R11 Net-_U1-STAT_ CHARGE_STAT 150k
R1 Net-_J1-CC1_ GND 5.1k
R6 GND Net-_Q1-G_ 1Meg
L1 Net-_U2-L1_ Net-_U2-L2_ 1.5u
XQ2 Net-_Q2-G_ +BATT /USB_+_Power/BOOST_IN AO3401A
C6 +3V3 GND 10u
R9 Net-_Q3-G_ GND 1Meg
XD1 SYS VBUS SS14_SUB
XU3 +5V Net-_U3-SW_ GND TPS613222A
R12 CHARGE_STAT GND 220k
R5 VBUS Net-_Q1-G_ 100k
C8 +5V GND 22u
R13 GND VBUS 47k
R8 BOOST_CMD Net-_Q3-G_ 10k
XU1 Net-_U1-STAT_ GND +BATT VBUS Net-_U1-PROG_ MCP73831
C5 +3V3 GND 10u
R2 Net-_J1-CC2_ GND 5.1k
C2 +BATT GND 4.7u
XQ1 Net-_Q1-G_ SYS +BATT AO3401A
XQ3 Net-_Q3-G_ GND Net-_Q2-G_ AO3400A
C9 UNNI_AC GND 1u
R3 Net-_U1-PROG_ GND 3.3k
XD4 UNNI_AC +5V SS14_SUB
R7 Net-_Q2-G_ +BATT 1Meg
C1 VBUS GND 4.7u
C4 SYS GND 100n
XU2 +3V3 Net-_U2-L2_ GND Net-_U2-L1_ SYS SYS GND SYS GND +3V3 GND TPS63031
L2 /USB_+_Power/BOOST_IN Net-_U3-SW_ 2.2u
XQ4 VBUS GND Net-_Q3-G_ AO3400A
C7 /USB_+_Power/BOOST_IN GND 10u
XD3 UNNI_AC VBUS SS14_SUB
C3 SYS GND 10u
R301 UNNI_AC GND 100
V3 BOOST_CMD GND PULSE( 0 3.3 0.5 5m 5m 4.5 6.5 )
R300 Net-_R300-Pad1_ +BATT 120m
XR310 Net-_R310-Pad1_ VBUS USB_HOTPLUG
V2 Net-_R300-Pad1_ GND DC 3.70
V1 Net-_R310-Pad1_ GND PULSE( 0 5 3 20m 20m 3 20 )
I1 +3V3 GND PULSE( 0.02 0.18 0.2 1m 1m 0.05 0.5 )
I2 SYS GND PULSE( 0.02 0.18 0.2 1m 1m 0.05 0.5 )
R302 +BATT GND 330
.end
