.title KiCad schematic
.include "/mnt/data/unni-smartification-c6-revA-v30-worstcase/spice/models/AO3400A.lib"
.include "/mnt/data/unni-smartification-c6-revA-v30-worstcase/spice/models/AO3401A.lib"
.include "/mnt/data/unni-smartification-c6-revA-v30-worstcase/spice/models/MCP73831.lib"
.include "/mnt/data/unni-smartification-c6-revA-v30-worstcase/spice/models/SS14.lib"
.include "/mnt/data/unni-smartification-c6-revA-v30-worstcase/spice/models/TPS613222A.lib"
.include "/mnt/data/unni-smartification-c6-revA-v30-worstcase/spice/models/TPS63031.lib"
.include "/mnt/data/unni-smartification-c6-revA-v30-worstcase/spice/models/USB_HOTPLUG.lib"
R2 Net-_J1-CC2_ GND 5.1k
R1 Net-_J1-CC1_ GND 5.1k
R6 GND Net-_Q1-G_ 1Meg
R5 VBUS Net-_Q1-G_ 100k
XD1 SYS VBUS SS14_SUB
XQ1 Net-_Q1-G_ SYS +BATT AO3401A
R12 CHARGE_STAT GND 220k
R8 BOOST_CMD Net-_Q3-G_ 10k
XQ3 Net-_Q3-G_ GND Net-_Q2-G_ AO3400A
XQ4 VBUS GND Net-_Q3-G_ AO3400A
R7 +BATT Net-_Q2-G_ 1Meg
R9 Net-_Q3-G_ GND 1Meg
XQ2 Net-_Q2-G_ +BATT /USB_+_Power/BOOST_IN AO3401A
C8 +5V GND 22u
C9 UNNI_AC GND 1u
XD4 UNNI_AC +5V SS14_SUB
XD3 UNNI_AC VBUS SS14_SUB
R3 Net-_U1-PROG_ GND 3.3k
C1 VBUS GND 4.7u
XU1 Net-_U1-STAT_ GND +BATT VBUS Net-_U1-PROG_ MCP73831
R11 Net-_U1-STAT_ CHARGE_STAT 150k
C2 +BATT GND 4.7u
XU2 +3V3 Net-_U2-L2_ GND Net-_U2-L1_ SYS SYS GND SYS GND +3V3 GND TPS63031
L1 Net-_U2-L1_ Net-_U2-L2_ 1.5u
C6 +3V3 GND 10u
C5 +3V3 GND 10u
C3 SYS GND 10u
C4 SYS GND 100n
R13 GND VBUS 47k
C7 /USB_+_Power/BOOST_IN GND 10u
L2 /USB_+_Power/BOOST_IN Net-_D2-A_ 2.2u
XU3 +5V Net-_D2-A_ GND TPS613222A
R302 +BATT GND 330
I2 SYS GND PULSE( 0.02 0.18 0.48 1m 1m 0.25 10 )
I1 +3V3 GND PULSE( 0.02 0.18 0.48 1m 1m 0.25 10 )
V3 BOOST_CMD GND PULSE( 0 3.3 0.5 5m 5m 4.5 6.5 )
V1 Net-_R310-Pad1_ GND PULSE( 0 5 3 20m 20m 3 20 )
V2 Net-_R300-Pad1_ GND DC 3.700
XR310 Net-_R310-Pad1_ VBUS USB_HOTPLUG
R300 Net-_R300-Pad1_ +BATT 0.100
R301 UNNI_AC GND 100

.control
set wr_singlescale
tran 100u 1.2s
wrdata case_3.7V_0.1ohm.csv time v(VBUS) v(+BATT) v(SYS) v(+3V3) v(+5V) v(UNNI_AC) v(BOOST_CMD) v(/USB_+_Power/BOOST_IN) i(V2)
.endc
.end
