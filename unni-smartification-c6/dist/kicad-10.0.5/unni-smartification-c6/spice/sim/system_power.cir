* Unni smartification Rev A - system power transient
.include ../models/AO3400A.lib
.include ../models/AO3401A.lib
.include ../models/SS14.lib
.include ../models/MCP73831.lib
.include ../models/TPS63031.lib
.include ../models/TPS613222A.lib
.include ../models/USB_HOTPLUG.lib

.param VBAT_OC=3.70
.param RBAT=0.12

* Battery with simple series impedance
VBAT0 bat0 0 {VBAT_OC}
RBAT bat0 batt {RBAT}
CBAT batt 0 2200u

* External USB: a 5 V source connected through a simulation-only hot-plug switch.
VUSB_SRC usbsrc 0 PULSE(0 5 120m 20u 20u 120m 400m)
XUSBHOT usbsrc usb USB_HOTPLUG
RUSBPD usb 0 47k

* MCP73831, RPROG=5.1k (~196mA nominal), autonomous charging.
* No ESP-controlled charge enable: a flat battery must still be able to charge.
RPROG prog 0 5.1k
XCHG chg_stat 0 batt usb prog MCP73831
RSTAT chg_stat 0 220k

* USB -> SYS Schottky, battery -> SYS AO3401A load-sharing path.
XDSYS sys usb SS14_SUB
* AO3401 model pins G S D. S=SYS, D=BAT gives body diode BAT->SYS at startup.
XQBAT qbat_g sys batt AO3401A
RQBATDN qbat_g 0 1Meg
RQBATUSB usb qbat_g 100k
CSYS sys 0 47u

* 3.3 V system-level buck-boost and representative ESP/radio load.
V3EN en3 0 3.3
X3V3 sys en3 3v3 0 TPS63031_SYS
C3V3 3v3 0 47u
IBASE 3v3 0 18m
IRADIO 3v3 0 PULSE(0 220m 20m 20u 20u 3m 20m)

* Forced-awake request 40..190ms. External USB independently inhibits it.
VREQ reqsrc 0 PULSE(0 3.3 40m 5u 5u 150m 400m)
RREQ reqsrc boost_cmd 10k
RREQDN boost_cmd 0 1Meg
XQINH usb 0 boost_cmd AO3400A
XQDRV boost_cmd 0 boost_gate AO3400A
RQHSPU batt boost_gate 1Meg
XQHS boost_gate batt boost_in AO3401A
CBOOSTIN boost_in 0 10u
XBOOST boost_in boost5 0 TPS613222A_SYS
CBOOST5 boost5 0 22u

* Safe source OR to Unni 5V input using SS14s.
XDUSBAC unni_ac usb SS14_SUB
XDBSTAC unni_ac boost5 SS14_SUB
CAC unni_ac 0 10u
BUNNIAC unni_ac 0 I={V(unni_ac)>3.5 ? 0.050 : 0}
* Unni's battery input remains directly on cell.
IUNNIDC batt 0 12m

.control
set wr_singlescale
tran 20u 300m
wrdata results/system_power.csv time v(usb) v(batt) v(sys) v(3v3) v(chg_stat) v(boost_cmd) v(boost_in) v(boost5) v(unni_ac)
.endc
.end
